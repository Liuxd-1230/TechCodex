Ch05 resistor-referenced OTA; 5 core MOS + 1 reference MOS
.include "design.ngspice"
.lib "sm141064.ngspice" typical
.param sw_stat_global=0 sw_stat_mismatch=0
.temp -20
.options reltol=1e-5 abstol=1e-13 vntol=1e-8
.options reltol=1e-8 abstol=1e-15 vntol=1e-11
Vdd vdd 0 3.3
Rref vdd b 59995.7461474
Vtail t dt 0
Xr b b 0 0 nmos_3p3 w=10u l=1u ad=5p as=5p pd=21u ps=21u
Xt dt b 0 0 nmos_3p3 w=20u l=1u ad=5p as=5p pd=21u ps=21u
Vcm cm 0 dc 1.4 ac 0
Vdiff diff 0 dc 0 ac 1
Ep ip cm diff 0 .5
En inn cm diff 0 -.5
X1 x ip t 0 nmos_3p3 w=10u l=1u ad=5p as=5p pd=21u ps=21u
X2 o inn t 0 nmos_3p3 w=10u l=1u ad=5p as=5p pd=21u ps=21u
X3 x x vdd vdd pmos_3p3 w=3.70816731131u l=1u ad=5p as=5p pd=21u ps=21u
X4 o x vdd vdd pmos_3p3 w=3.70816731131u l=1u ad=5p as=5p pd=21u ps=21u
.control
set noaskquit
set wr_singlescale
set wr_vecnames
set numdgt=15
save all @m.x1.m0[gm] @m.x1.m0[gmbs] @m.x1.m0[gds] @m.x1.m0[vdsat] @m.x2.m0[gm] @m.x2.m0[gmbs] @m.x2.m0[gds] @m.x2.m0[vdsat] @m.x3.m0[gm] @m.x3.m0[gmbs] @m.x3.m0[gds] @m.x3.m0[vdsat] @m.x4.m0[gm] @m.x4.m0[gmbs] @m.x4.m0[gds] @m.x4.m0[vdsat] @m.xt.m0[gm] @m.xt.m0[gmbs] @m.xt.m0[gds] @m.xt.m0[vdsat]
op
let isupply = -i(Vdd)
wrdata op.txt v(x) v(o) v(t) v(b) isupply i(Vtail) @m.x1.m0[gm] @m.x1.m0[gmbs] @m.x1.m0[gds] @m.x1.m0[vdsat] @m.x2.m0[gm] @m.x2.m0[gmbs] @m.x2.m0[gds] @m.x2.m0[vdsat] @m.x3.m0[gm] @m.x3.m0[gmbs] @m.x3.m0[gds] @m.x3.m0[vdsat] @m.x4.m0[gm] @m.x4.m0[gmbs] @m.x4.m0[gds] @m.x4.m0[vdsat] @m.xt.m0[gm] @m.xt.m0[gmbs] @m.xt.m0[gds] @m.xt.m0[vdsat]
ac lin 1 1 1
wrdata dm.txt v(o)
alter @vdiff[acmag] = 0
alter @vcm[acmag] = 1
ac lin 1 1 1
wrdata cm.txt v(o)
dc Vdiff -.0001 .0001 .0001
wrdata linear.txt v(o)
dc Vcm .7 2.8 .01
wrdata common.txt v(x) v(o) v(t) @m.x1.m0[vdsat] @m.x2.m0[vdsat] @m.x3.m0[vdsat] @m.x4.m0[vdsat] @m.xt.m0[vdsat]

quit
.endc
.end

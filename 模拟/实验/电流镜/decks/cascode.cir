Ch05 mirror
.include "design.ngspice"
.lib "sm141064.ngspice" typical
.param sw_stat_global=0 sw_stat_mismatch=0
.temp 27
.options reltol=1e-5 abstol=1e-13 vntol=1e-8
.options reltol=1e-9 abstol=1e-16 vntol=1e-12
Vdd vdd 0 3.3
Vout o 0 1.65
Iref vdd bc 40u
X1 b b 0 0 nmos_3p3 w=10u l=1u ad=5p as=5p pd=21u ps=21u
X3 bc bc b 0 nmos_3p3 w=10u l=1u ad=5p as=5p pd=21u ps=21u
X2 x b 0 0 nmos_3p3 w=10u l=1u ad=5p as=5p pd=21u ps=21u
X4 o bc x 0 nmos_3p3 w=10u l=1u ad=5p as=5p pd=21u ps=21u
.control
set noaskquit
set wr_singlescale
set wr_vecnames
set numdgt=15
save all @m.x2.m0[vdsat] @m.x4.m0[vdsat]
dc Vout .05 3.0 .01
let io = -i(Vout)
wrdata sweep.txt io v(b) v(x) @m.x2.m0[vdsat] @m.x4.m0[vdsat]

quit
.endc
.end

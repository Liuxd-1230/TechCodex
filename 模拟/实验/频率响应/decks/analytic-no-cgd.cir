Ch06 explicit linear CS teaching model
Vin in 0 ac 1
Rsig in g 10k
Ro o 0 50k
Gm o 0 g 0 1m
Ci g 0 1p
Co o 0 1p
Cf g o 1e-30
.control
set noaskquit
set wr_singlescale
set wr_vecnames
set numdgt=15
ac dec 80 1 10G
wrdata ac.txt v(o) v(g)
quit
.endc
.end

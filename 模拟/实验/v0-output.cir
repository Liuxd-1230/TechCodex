V0 GF180MCU output curves: W/L=10um/1um, Vg substituted by runner
.include "design.ngspice"
.lib "sm141064.ngspice" typical
.param sw_stat_global=0 sw_stat_mismatch=0
.temp 27
.options reltol=1e-5 abstol=1e-13 vntol=1e-8
Vd d 0 1.65
Vg g 0 @VG@
X1 d g 0 0 nmos_3p3 w=10u l=1u ad=5p as=5p pd=21u ps=21u
.control
set noaskquit
set wr_singlescale
set wr_vecnames
save v(d) @m.x1.m0[id] @m.x1.m0[gds]
dc Vd 0 3.3 .01
wrdata output.txt @m.x1.m0[id] @m.x1.m0[gds]
quit
.endc
.end
